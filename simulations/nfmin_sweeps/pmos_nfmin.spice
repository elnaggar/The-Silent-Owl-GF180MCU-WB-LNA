.option savecurrents

.param fnoicor=0
.param sw_stat_mismatch=0

.lib /home/ttuser/pdk/gf180mcuD/libs.tech/ngspice/sm141064.ngspice typical

* Default values
.param VDDP=1.8
.param VSG_BIAS=0.7
.param VG_BIAS={VDDP-VSG_BIAS}

.param W=0.22e-6
.param L=0.28e-6

.control
  set noaskquit
  save all

  echo "W_m L_m VSG ID_A JD_mA_per_um" > pmos_geom_jd.txt
  echo "W_m L_m VSG NFmin_dB NF_dB Rn SOpt_real SOpt_imag" > pmos_geom_nf.txt

  * Width sweep in meters:
  * 0.22um = minimum
  * 1um, 5um, 10um = larger devices
  foreach wval 0.22e-6 1e-6 5e-6 10e-6

    * Length sweep in meters:
    foreach lval 0.28e-6 0.36e-6 0.50e-6

      foreach vsg 0.35 0.40 0.45 0.50 0.55 0.60 0.65 0.70 0.75 0.80 0.90 1.00 1.10 1.20

        alterparam W = $wval
        alterparam L = $lval
        alterparam VSG_BIAS = $vsg
        reset

        op

        let idp_op = abs(i(vds))
        let jd_p_op = 1e-3*idp_op/$wval

        echo $wval $lval $vsg $&idp_op $&jd_p_op >> pmos_geom_jd.txt

        sp lin 1 2.4e9 2.4e9 1

        let nfmin_val = real(NFmin)
        let nf_val = real(NF)
        let rn_val = real(Rn)
        let sopt_re = real(SOpt)
        let sopt_im = imag(SOpt)

        echo $wval $lval $vsg $&nfmin_val $&nf_val $&rn_val $&sopt_re $&sopt_im >> pmos_geom_nf.txt

      end

    end

  end

.endc
