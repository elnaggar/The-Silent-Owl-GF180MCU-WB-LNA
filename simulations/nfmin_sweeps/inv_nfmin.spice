.option savecurrents

.param fnoicor=0
.param sw_stat_mismatch=0

.lib /home/ttuser/pdk/gf180mcuD/libs.tech/ngspice/sm141064.ngspice typical

.param VDD=1.8
.param VCM=0.9

* Default geometry values
.param N_W=0.22e-6
.param N_L=0.28e-6
.param P_W=0.66e-6
.param P_L=0.28e-6

.control
  set noaskquit
  save all

  echo "N_W_m N_L_m P_W_m P_L_m VCM ID_A JD_N_mA_per_um JD_P_mA_per_um VOUT_DC" > inv_geom_jd.txt
  echo "N_W_m N_L_m P_W_m P_L_m VCM NFmin_dB NF_dB Rn SOpt_real SOpt_imag" > inv_geom_nf.txt

  * NMOS width sweep
  foreach nwval 0.22e-6 1e-6 5e-6 10e-6

    * NMOS length sweep
    foreach nlval 0.28e-6 0.36e-6 0.50e-6

      * PMOS width sweep
      foreach pwval 0.66e-6 2e-6 10e-6 20e-6 30e-6

        * PMOS length sweep
        foreach plval 0.28e-6 0.36e-6 0.50e-6

          * Common gate bias sweep
          foreach vcm 0.55 0.60 0.65 0.70 0.75 0.80 0.85 0.90 0.95 1.00 1.05 1.10 1.15

            alterparam N_W = $nwval
            alterparam N_L = $nlval
            alterparam P_W = $pwval
            alterparam P_L = $plval
            alterparam VCM = $vcm
            reset

            op

            let id_inv = abs(i(vvdd))
            let jd_n = 1e-3*id_inv/$nwval
            let jd_p = 1e-3*id_inv/$pwval
            let vout_dc = v(d)

            echo $nwval $nlval $pwval $plval $vcm $&id_inv $&jd_n $&jd_p $&vout_dc >> inv_geom_jd.txt

            sp lin 1 2.4e9 2.4e9 1

            let nfmin_val = real(NFmin)
            let nf_val = real(NF)
            let rn_val = real(Rn)
            let sopt_re = real(SOpt)
            let sopt_im = imag(SOpt)

            echo $nwval $nlval $pwval $plval $vcm $&nfmin_val $&nf_val $&rn_val $&sopt_re $&sopt_im >> inv_geom_nf.txt

          end

        end

      end

    end

  end

.endc
