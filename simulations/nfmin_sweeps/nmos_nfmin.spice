.option savecurrents

.param fnoicor=0
.param sw_stat_mismatch=0

.lib /home/ttuser/pdk/gf180mcuD/libs.tech/ngspice/sm141064.ngspice typical

.param VBIAS=0.7
.param VDS=1.8

.param W=0.22e-6
.param L=0.28e-6

.control
  set noaskquit
  save all

  echo "W_m L_m VGS ID_A JD_mA_per_um" > nmos_geom_jd.txt
  echo "W_m L_m VGS NFmin_dB NF_dB Rn SOpt_real SOpt_imag" > nmos_geom_nf.txt

  foreach wval 0.22e-6 1e-6 5e-6 10e-6

    foreach lval 0.28e-6 0.36e-6 0.50e-6

      foreach vbias 0.35 0.40 0.45 0.50 0.55 0.60 0.65 0.70 0.75 0.80 0.90 1.00 1.10 1.20

        alterparam W = $wval
        alterparam L = $lval
        alterparam VBIAS = $vbias
        reset

        op

        let idn_op = abs(i(vdd))
        let jd_n_op = 1e-3*idn_op/$wval

        echo $wval $lval $vbias $&idn_op $&jd_n_op >> nmos_geom_jd.txt

        sp lin 1 2.4e9 2.4e9 1

        let nfmin_val = real(NFmin)
        let nf_val = real(NF)
        let rn_val = real(Rn)
        let sopt_re = real(SOpt)
        let sopt_im = imag(SOpt)

        echo $wval $lval $vbias $&nfmin_val $&nf_val $&rn_val $&sopt_re $&sopt_im >> nmos_geom_nf.txt

      end

    end

  end

.endc
