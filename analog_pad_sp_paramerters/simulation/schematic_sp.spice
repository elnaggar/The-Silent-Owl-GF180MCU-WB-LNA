** sch_path: /foss/designs/GF180/sscs_chipathon_26/LNA/schematic_sp.sch
**.subckt schematic_sp
x1 DVDD Vin 0 VDD 0 gf180mcu_fd_io__asig_5p0
V1 Vin 0 dc 0 ac 1 portnum 1 z0 50
V_VDD VDD 0 6
V_DVDD DVDD 0 6
V_Dummy net1 0 dc 0 ac 1 portnum 2 z0 50
R1 net1 0 50
**** begin user architecture code

.control
save all
sp lin 100 1e3 5e9 0
write sp_analog_pad.raw
.endc

.include /foss/pdks/gf180mcuD/libs.tech/ngspice/design.ngspice
.lib /foss/pdks/gf180mcuD/libs.tech/ngspice/sm141064.ngspice typical
.lib /foss/pdks/gf180mcuD/libs.tech/ngspice/sm141064.ngspice res_typical
.lib /foss/pdks/gf180mcuD/libs.tech/ngspice/sm141064.ngspice moscap_typical
.lib /foss/pdks/gf180mcuD/libs.tech/ngspice/sm141064.ngspice diode_typical
.include /foss/pdks/gf180mcuD/libs.ref/gf180mcu_fd_io/spice/gf180mcu_fd_io.spice
*.include /foss/pdks/gf180mcuD/libs.ref/gf180mcu_fd_io/spice/gf180mcu_ef_io.spice

**** end user architecture code
**.ends
.end
