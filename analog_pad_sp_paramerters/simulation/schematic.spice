** sch_path: /foss/designs/GF180/sscs_chipathon_26/LNA/schematic.sch
**.subckt schematic
x1 DVDD Vin 0 VDD 0 gf180mcu_fd_io__asig_5p0
V1 Vin 0 dc 0 ac 1
V_VDD VDD 0 5
V_DVDD DVDD 0 5
**** begin user architecture code

.control
save all
ac dec 1000 10e3 2e9
*sp lin 100 1e3 2e9 0
write ac_analog_pad.raw
.endc

.include /foss/pdks/gf180mcuD/libs.tech/ngspice/design.ngspice
.lib /foss/pdks/gf180mcuD/libs.tech/ngspice/sm141064.ngspice typical
.lib /foss/pdks/gf180mcuD/libs.tech/ngspice/sm141064.ngspice res_typical
.lib /foss/pdks/gf180mcuD/libs.tech/ngspice/sm141064.ngspice moscap_typical
.lib /foss/pdks/gf180mcuD/libs.tech/ngspice/sm141064.ngspice diode_typical
.include /foss/pdks/gf180mcuD/libs.ref/gf180mcu_fd_io/spice/gf180mcu_fd_io.spice

**** end user architecture code
**.ends
.end
